** sch_path: /foss/designs/ChipAcharya/DSM/DSM_1storder/xschem/DSM_with_clock.sch
**.subckt DSM_with_clock
C1 net1 net2 0.25p m=1
S2 net3 net2 ph2 trip SW1
S3 net1 net4 ph2 trip SW1
S4 net2 VCM ph1 trip SW1
VDD VDD GND dc {vdd}
VCM1 VCM GND dc {vdd/2}
C2 net3 VOUT 1p m=1
x1 q net5 ph1 vcmp resb VDD VSS sg13g2_dfrbp_1
Vresb resb GND dc 0 pwl(0, 0, {per/2}, 0, {per/2+100p} {vdd})
x2 net4 vcmp 1.5 0 sg13g2_inv_1
x3 VOUT VCM net3 ideal_opamp
x4 VDD vcmp VCM ph2 VOUT ideal_comparator
S1 VIN net1 ph1 trip SW1
Etrip trip GND VDD GND {Etrip}
Vin VIN GND SINE(1.5 1.4 80)
x5 ph1 clkin ph2 ClkG
Vss VSS GND dc 0
Vp1 clkin GND dc 0 pulse(0, {vdd}, 0, 100p, 100p, 2.25n, 4.5n)
**** begin user architecture code

.control
save all

tran 100n 10us 0 20n uic
plot v(VIN)
plot v(VOUT)
plot v(q)
plot v(vcmp)

.endc

.lib /foss/pdks/ihp-sg13g2/libs.tech/ngspice/models/cornerMOSlv.lib mos_tt
.lib /foss/pdks/ihp-sg13g2/libs.tech/ngspice/models/cornerRES.lib res_typ
.inc /foss/pdks/ihp-sg13g2/libs.ref/sg13g2_stdcell/spice/sg13g2_stdcell.spice

.param Etrip=0.5
.param per=1u
.param temp=27
.param vdd=3

**** end user architecture code
**.ends

* expanding   symbol:  ideal_opamp.sym # of pins=3
** sym_path: /foss/designs/ChipAcharya/DSM/DSM_1storder/xschem/ideal_opamp.sym
** sch_path: /foss/designs/ChipAcharya/DSM/DSM_1storder/xschem/ideal_opamp.sch
.subckt ideal_opamp out inp inn
*.opin out
*.ipin inp
*.ipin inn
E1 out GND inp inn 1Meg
R1 out GND 100Meg m=1
.ends

* expanding   symbol:  ideal_comparator.sym # of pins=5
** sym_path: /foss/designs/ChipAcharya/DSM/DSM_1storder/xschem/ideal_comparator.sym
** sch_path: /foss/designs/ChipAcharya/DSM/DSM_1storder/xschem/ideal_comparator.sch
.subckt ideal_comparator Vdd Vout Vinp clk Vinn
*.ipin Vinp
*.ipin Vinn
*.opin Vout
*.iopin Vdd
*.iopin clk
E1 diff GND Vinp Vinn 1
S1 diff sample tp clk SW1
E2 net1 GND sample GND 1
C1 sample GND 100p m=1
S2 net1 hold clk tp SW1
C2 hold GND 100p m=1
B1 Vout GND V={v(hold)>0?v(Vdd):0}
Etp tp GND Vdd GND 0.5
**** begin user architecture code

.ic v(hold)=1 v(sample)=1

**** end user architecture code
**** begin user architecture code

.param vdd=1.5

**** end user architecture code
.ends

* expanding   symbol:  /foss/designs/CEMS_DSM/CEMS_G2/DSM/Schematics/Ideal_Circuits/Clock/ClkG.sym # of pins=3
** sym_path: /foss/designs/CEMS_DSM/CEMS_G2/DSM/Schematics/Ideal_Circuits/Clock/ClkG.sym
** sch_path: /foss/designs/CEMS_DSM/CEMS_G2/DSM/Schematics/Ideal_Circuits/Clock/ClkG.sch
.subckt ClkG p1 clkin p2
*.ipin clkin
*.opin p1
*.opin p2
xn1 net10 clkinbb b2 VDD VSS sg13g2_nand2_2
xi7 net8 net5 VDD VSS sg13g2_inv_4
xi1 clkinb clkin VDD VSS sg13g2_inv_2
xi2 clkinbb clkinb VDD VSS sg13g2_inv_2
xn2 net11 clkinb b1 VDD VSS sg13g2_nand2_2
xi13 b1 net14 VDD VSS sg13g2_inv_4
xi8 net9 net7 VDD VSS sg13g2_inv_4
xi14 b2 net1 VDD VSS sg13g2_inv_4
xn3 net13 a1 b1 VDD VSS sg13g2_nand2_2
xn4 net2 a2 b2 VDD VSS sg13g2_nand2_2
xi11 net14 a1 VDD VSS sg13g2_inv_4
xi9 a1 net8 VDD VSS sg13g2_inv_4
x12 net1 a2 VDD VSS sg13g2_inv_4
xi10 a2 net9 VDD VSS sg13g2_inv_4
xi15 net12 net13 VDD VSS sg13g2_inv_4
xi17 p1 net12 VDD VSS sg13g2_inv_8
xi16 net3 net2 VDD VSS sg13g2_inv_4
xi18 p2 net3 VDD VSS sg13g2_inv_8
xi3 net4 net10 VDD VSS sg13g2_inv_4
xi5 net5 net4 VDD VSS sg13g2_inv_4
xi4 net6 net11 VDD VSS sg13g2_inv_4
xi6 net7 net6 VDD VSS sg13g2_inv_4
.ends

.GLOBAL GND
.GLOBAL VDD
.GLOBAL VCM
.GLOBAL VSS
**** begin user architecture code
.MODEL SW1 SW( VT=0.9 VH=0.01 RON=0.01 ROFF=10G )
.MODEL SW1 SW(VT=0.5 VH=0 RON=0.1 ROFF=100M)
**** end user architecture code
.end
