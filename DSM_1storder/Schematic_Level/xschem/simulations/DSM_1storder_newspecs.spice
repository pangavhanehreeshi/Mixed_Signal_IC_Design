** sch_path: /foss/designs/ChipAcharya/DSM/DSM_1storder/xschem/DSM_1storder_newspecs.sch
**.subckt DSM_1storder_newspecs
C1 net1 net2 0.25p m=1
S2 net3 net2 ph2 trip SW1
S3 net1 net4 ph2 trip SW1
S4 net2 VCM ph1 trip SW1
VDD VDD GND dc {vdd}
VCM1 VCM GND dc {vdd/2}
Vph2 ph2 GND PULSE(0V 1.5V 2.25us 100ns 100ns 2us 4.5us)
Vph1 ph1 GND PULSE(0V 1.5V 0ns 100ns 100ns 2us 4.5us)
C2 net3 VOUT 1p m=1
x1 q net5 ph1 vcmp resb VDD VSS sg13g2_dfrbp_1
Vresb resb GND dc 0 pwl(0, 0, {per/2}, 0, {per/2+100p}, {vdd})
x2 net4 vcmp VDD VSS sg13g2_inv_1
S1 VIN net1 ph1 trip SW1
Etrip trip GND VDD GND {Etrip}
Vin VIN GND SINE(0.75 0.65 512)
x3 VOUT VCM net3 idealopampa_newspecs
x4 VDD vcmp VCM ph2 VOUT comparator_newspecs
**** begin user architecture code

.control
save all

tran 10ms
plot v(VIN)
plot v(VOUT)
plot v(q)
plot v(vcmp)

.endc

.lib /foss/pdks/ihp-sg13g2/libs.tech/ngspice/models/cornerMOSlv.lib mos_tt
.lib /foss/pdks/ihp-sg13g2/libs.tech/ngspice/models/cornerRES.lib res_typ
.inc /foss/pdks/ihp-sg13g2/libs.ref/sg13g2_stdcell/spice/sg13g2_stdcell.spice

.param Etrip=0.75
.param per=4.5u
.param temp=27
.param vdd=1.5

**** end user architecture code
**.ends

* expanding   symbol:  idealopampa_newspecs.sym # of pins=3
** sym_path: /foss/designs/ChipAcharya/DSM/DSM_1storder/xschem/idealopampa_newspecs.sym
** sch_path: /foss/designs/ChipAcharya/DSM/DSM_1storder/xschem/idealopampa_newspecs.sch
.subckt idealopampa_newspecs out inp inn
*.opin out
*.ipin inp
*.ipin inn
E1 net1 GND inp inn 1Meg
R1 out GND 100Meg m=1
R2 net1 out 1000 m=1
.ends

* expanding   symbol:  comparator_newspecs.sym # of pins=5
** sym_path: /foss/designs/ChipAcharya/DSM/DSM_1storder/xschem/comparator_newspecs.sym
** sch_path: /foss/designs/ChipAcharya/DSM/DSM_1storder/xschem/comparator_newspecs.sch
.subckt comparator_newspecs Vdd Vout Vinp clk Vinn
*.ipin Vinp
*.ipin Vinn
*.opin Vout
*.iopin Vdd
*.iopin clk
E1 diff GND Vinp Vinn 1
S1 diff sample tp clk SW1
E2 net1 GND sample GND 1
C1 sample GND 100p m=1
S2 net1 hold clk tp SW1
C2 hold GND 100p m=1
B1 net2 GND V={v(hold)>0?v(Vdd):0}
Etp tp GND Vdd GND 0.75
**** begin user architecture code

.ic v(hold)=1 v(sample)=1

**** end user architecture code
**** begin user architecture code

.param vdd=1.5

**** end user architecture code
C3 Vout GND 100f m=1
R2 net2 Vout 1000 m=1
.ends

.GLOBAL GND
.GLOBAL VDD
.GLOBAL VCM
.GLOBAL ph2
.GLOBAL ph1
**** begin user architecture code
.MODEL SW1 SW(VT=0.75 VH=0.05 RON=0.1 ROFF=100M)
.MODEL SW1 SW( VT=0.4 VH=0.01 RON=0.01 ROFF=10G )
**** end user architecture code
.end
