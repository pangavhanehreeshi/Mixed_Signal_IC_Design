** sch_path: /foss/designs/drms-elie3/2_ideal_circuits/ideal_modulator.sch
**.subckt ideal_modulator Vdd Vin out phi1 phi2 trip Vref Vcm vss
*.ipin Vin
*.ipin phi1
*.ipin trip
*.ipin phi2
*.ipin Vcm
*.ipin Vref
*.iopin vss
S1 Vin net1 phi1 trip SW1
S2 net1 Vfb phi2 trip SW1
S3 diff net2 phi2 trip SW1
S4 net2 Vcm phi1 trip SW1
C2 diff Vint {C2} m=1
C1 net1 net2 {C1} m=1
x1 Vcm diff Vint ideal_opamp
x3 Vdd cmp Vint Vcm phi1 ideal_comparator
x4 Vfb net3 vss Vref ideal_inverter
x2 net3 net4 phi1 cmp resb VDD VSS sg13g2_dfrbp_1
Vresb resb GND dc 0 pwl(0, 0, {per/2}, 0, {per/2+100p} {vdd}
Vdd Vdd GND {Vdd}
**.ends

* expanding   symbol:  /foss/designs/drms-elie3/2_ideal_circuits/ideal_opamp.sym # of pins=3
** sym_path: /foss/designs/drms-elie3/2_ideal_circuits/ideal_opamp.sym
** sch_path: /foss/designs/drms-elie3/2_ideal_circuits/ideal_opamp.sch
.subckt ideal_opamp inp inn out
*.opin out
*.ipin inp
*.ipin inn
E1 out GND inp inn 1Meg
R1 out GND 100Meg m=1
.ends

* expanding   symbol:  /foss/designs/drms-elie3/2_ideal_circuits/ideal_comparator.sym # of pins=5
** sym_path: /foss/designs/drms-elie3/2_ideal_circuits/ideal_comparator.sym
** sch_path: /foss/designs/drms-elie3/2_ideal_circuits/ideal_comparator.sch
.subckt ideal_comparator Vdd Vout Vinn Vinp clk
*.ipin Vinp
*.ipin Vinn
*.opin Vout
*.iopin Vdd
*.iopin clk
E1 diff GND Vinp Vinn 1
S1 diff sample tp clk SW1
E2 net1 GND sample GND 1
C1 sample GND 100p m=1
S2 net1 hold clk tp SW1
C2 hold GND 100p m=1
B1 Vout GND V={v(hold)>0?v(Vdd):0}
Etp tp GND Vdd GND 0.5
**** begin user architecture code

.ic v(hold)=1 v(sample)=1

**** end user architecture code
.ends

* expanding   symbol:  /foss/designs/drms-elie3/2_ideal_circuits/ideal_inverter.sym # of pins=4
** sym_path: /foss/designs/drms-elie3/2_ideal_circuits/ideal_inverter.sym
** sch_path: /foss/designs/drms-elie3/2_ideal_circuits/ideal_inverter.sch
.subckt ideal_inverter out in vss vdd
*.iopin vdd
*.ipin in
*.opin out
*.iopin vss
B1 out GND V={v(in)>v(vdd)/2?v(vss):v(vdd)}
* noconn vdd
* noconn in
* noconn vss
.ends

.GLOBAL GND
**** begin user architecture code
.MODEL SW1 SW( VT=0.9 VH=0.01 RON=0.01 ROFF=10G )
**** end user architecture code
.end
