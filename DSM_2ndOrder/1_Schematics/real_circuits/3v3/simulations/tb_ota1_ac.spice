** sch_path: /foss/designs/ChipAcharya/DSM/DSM_2ndOrder/1_Schematics/real_circuits/tb_ota1_ac.sch
**.subckt tb_ota1_ac
Vss v_ss GND 0
Vdd v_dd GND 3.3
Vin v_in v_ss dc 1.5 ac 12
.save v(v_in)
I0 v_dd net1 0.5e-03
C1 v_out v_ss 2p m=1
.save v(v_out)
Venable v_ena v_ss 3.3
x1 v_dd net1 v_out v_in v_out v_ena v_ss OTA1
**** begin user architecture code
 .lib cornerMOShv.lib mos_tt

.temp 27
.control
option sparse
save all

* ---------- AC analysis ----------
op
ac dec 101 1k 1G

* Make sure the current plot is the AC plot
setplot ac1
remzerovec

* Measurements on AC
meas ac dcgain MAX vmag(v_out) FROM=10 TO=10k
let f3db = dcgain/sqrt(2)
meas ac fbw WHEN vmag(v_out)=f3db FALL=1
let gainerror=(dcgain-1)/1
print dcgain
print fbw
print gainerror

* (optional) interactive plots inside ngspice
plot 20*log10(v_out)
plot 180/pi*ph(v_out) vs frequency

* Write ONLY the AC plot to this file
write tb_foldedcascode_nmos_2_ac.raw

* ---------- Noise analysis ----------
noise v(v_out) Vin dec 101 1k 100MEG
print onoise_total

* Make sure current plot is the noise plot
setplot noise1

* Write the noise plot to a separate file
write tb_foldedcascode_nmos_noise.raw

.endc

**** end user architecture code
**.ends

* expanding   symbol:  OTA1.sym # of pins=7
** sym_path: /foss/designs/ChipAcharya/DSM/DSM_2ndOrder/1_Schematics/real_circuits/OTA1.sym
** sch_path: /foss/designs/ChipAcharya/DSM/DSM_2ndOrder/1_Schematics/real_circuits/OTA1.sch
.subckt OTA1 AVDD IBIAS VOUT MINUS PLUS D_ENA AVSS
*.ipin AVSS
*.ipin IBIAS
*.ipin AVDD
*.ipin PLUS
*.ipin MINUS
*.opin VOUT
*.ipin D_ENA
XM23 IBIAS net3 AVSS AVSS sg13_hv_nmos w=3313.12u l=5u ng=1000 m=1
XM25 IBIAS net2 net3 AVSS sg13_hv_nmos w=1u l=0.5u ng=1 m=1
XM24 net10 net3 AVSS AVSS sg13_hv_nmos w=1666.5u l=5u ng=1000 m=1
XM19 net10 net5 net4 AVDD sg13_hv_pmos w=13284.5u l=5u ng=10000 m=1
XM20 net4 net4 AVDD AVDD sg13_hv_pmos w=11250.5u l=5u ng=10000 m=1
XM21 AVSS net5 net8 AVDD sg13_hv_pmos w=14u l=0.5u ng=4 m=1
XM22 net8 net4 AVDD AVDD sg13_hv_pmos w=11250.5u l=5u ng=10000 m=1
XM26 net7 net4 AVDD AVDD sg13_hv_pmos w=11250.5u l=5u ng=10000 m=1
XM27 net5 net8 net7 AVDD sg13_hv_pmos w=13280.5u l=5u ng=10000 m=1
XM28 net5 net15 net6 AVSS sg13_hv_nmos w=2615u l=5u ng=1000 m=1
XM29 net6 net5 AVSS AVSS sg13_hv_nmos w=2038.5u l=5u ng=1000 m=1
XM30 net9 net3 AVSS AVSS sg13_hv_nmos w=1666.5u l=5u ng=1000 m=1
XM31 net7 PLUS net9 AVSS sg13_hv_nmos w=7617u l=5u ng=1000 m=1
XM32 net11 MINUS net9 AVSS sg13_hv_nmos w=7617u l=5u ng=1000 m=1
XM42 AVDD net4 AVDD AVDD sg13_hv_pmos w=12u l=0.5u ng=4 m=1
XM41 AVDD net8 AVDD AVDD sg13_hv_pmos w=12u l=0.5u ng=4 m=1
XM38 AVSS net3 AVSS AVSS sg13_hv_nmos w=8u l=1u ng=4 m=1
XM33 net1 D_ENA AVDD AVDD sg13_hv_pmos w=1u l=0.5u ng=1 m=1
XM34 net2 net1 AVDD AVDD sg13_hv_pmos w=1u l=0.5u ng=1 m=1
XM35 net1 D_ENA AVSS AVSS sg13_hv_nmos w=1u l=0.5u ng=1 m=1
XM36 net2 net1 AVSS AVSS sg13_hv_nmos w=1u l=0.5u ng=1 m=1
XM37 net11 AVSS AVSS AVSS sg13_hv_nmos w=7617u l=5u ng=1000 m=1
XM39 VOUT net8 net11 AVDD sg13_hv_pmos w=13280.5u l=5u ng=10000 m=1
XM40 net11 net4 AVDD AVDD sg13_hv_pmos w=11250.5u l=5u ng=10000 m=1
XM43 VOUT net15 net12 AVSS sg13_hv_nmos w=2615u l=5u ng=1000 m=1
XM44 net12 net5 AVSS AVSS sg13_hv_nmos w=2038.5u l=5u ng=1000 m=1
XM45 net12 AVSS AVSS AVSS sg13_hv_nmos w=2038.5u l=5u ng=1000 m=1
XM46 VOUT AVSS AVSS AVSS sg13_hv_nmos w=2615u l=5u ng=1000 m=1
XM47 net11 AVDD AVDD AVDD sg13_hv_pmos w=11250.5u l=5u ng=10000 m=1
XM48 VOUT AVDD AVDD AVDD sg13_hv_pmos w=13280.5u l=5u ng=10000 m=1
XM49 net13 net4 AVDD AVDD sg13_hv_pmos w=11250.5u l=5u ng=10000 m=1
XM50 net13 VOUT net14 AVSS sg13_hv_nmos w=2615u l=5u ng=1000 m=1
XM51 net14 net14 AVSS AVSS sg13_hv_nmos w=2615u l=5u ng=1000 m=1
XM52 net15 net14 AVSS AVSS sg13_hv_nmos w=2615u l=5u ng=1000 m=1
XM53 AVDD VOUT net15 AVSS sg13_hv_nmos w=15u l=0.5u ng=4 m=1
XM54 AVSS net15 AVSS AVSS sg13_hv_nmos w=8u l=1u ng=4 m=1
XM55 net5 net1 AVSS AVSS sg13_hv_nmos w=1u l=0.5u ng=1 m=1
XM56 net7 AVSS AVSS AVSS sg13_hv_nmos w=7617u l=5u ng=1000 m=1
XM57 net5 AVDD AVDD AVDD sg13_hv_pmos w=13280.5u l=5u ng=10000 m=1
XM58 net6 AVSS AVSS AVSS sg13_hv_nmos w=2038.5u l=5u ng=1000 m=1
XM59 net5 AVSS AVSS AVSS sg13_hv_nmos w=2615u l=5u ng=1000 m=1
XM60 net4 AVDD AVDD AVDD sg13_hv_pmos w=11250.5u l=5u ng=10000 m=1
XM61 net14 AVSS AVSS AVSS sg13_hv_nmos w=2615u l=5u ng=1000 m=1
.ends

.GLOBAL GND
.end
