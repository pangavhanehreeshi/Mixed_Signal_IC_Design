** sch_path: /foss/designs/ChipAcharya/DSM/DSM_2ndOrder/1_Schematics/real_circuits/loopgain_otasimple.sch
**.subckt loopgain_otasimple
Vdd v_dd GND 1.5
Vss v_ss GND 0
Vin v_in v_ss dc 0.7
Venable v_ena v_ss 1.5
C2 vr1 v_ss 2p m=1
I1 v_dd net1 301.5u
Vtest1 vf1 vr1 dc 0 ac 1
C1 net2 v_ss 2p m=1
I2 v_dd net3 301.5u
Vir1 net2 net5 0
.save i(vir1)
Vif1 net5 net4 0
.save i(vif1)
Itest1 v_ss net5 dc 0 ac 1
C3 net6 v_ss 2p m=1
I3 v_dd net7 301.5u
C4 net8 v_ss 2p m=1
I4 v_dd net9 301.5u
Itest3 v_ss vmeas1 dc 0 ac 0
Vtest2 vmeas1 net10 dc 0 ac 1
Vimeas1 net6 net10 0
.save i(vimeas1)
Itest2 v_ss vmeas2 dc 0 ac 1
Vtest3 vmeas2 net11 dc 0 ac 0
Vimeas2 net8 net11 0
.save i(vimeas2)
x1 v_dd v_in vmeas1 net6 net7 v_ena v_ss ota1_simple
x2 v_dd v_in vmeas2 net8 net9 v_ena v_ss ota1_simple
x3 v_dd v_in vf1 vr1 net1 v_ena v_ss ota1_simple
x4 v_dd v_in net4 net2 net3 v_ena v_ss ota1_simple
**** begin user architecture code

.lib cornerMOSlv.lib mos_tt
.lib cornerRES.lib res_typ

.param temp=27
.options savecurrents reltol=1e-3 abstol=1e-12 gmin=1e-15
.control
save all

* Operating Point Analysis
op
remzerovec
write ota-improved_tb-loopgain.raw
set appendwrite

* AC Analysis
ac dec 101 1 100G
remzerovec
write ota-improved_tb-loopgain.raw
set appendwrite

* Middlebrook's Method
let tv=-v(vr1)/v(vf1)
let ti=-i(vir1)/i(vif1)
let tmb=(tv*ti - 1)/(tv + ti + 2)

plot db(tmb) ylabel 'Magnitude - Middlebrook'
plot 180/pi*cphase(tmb) ylabel 'Phase - Middlebrook'

* Tian's Method
* vtest=0, itest=1:
let A=i(Vimeas2)
let C=v(vmeas2)

* vtest=1, itest=0:
let B=i(Vimeas1)
let D=v(vmeas1)
let ttian=(A*D-B*C-A)/(2*(B*C-A*D)+A-D+1)

plot db(ttian) ylabel 'Magnitude - Tian'
plot 180/pi*cphase(ttian) ylabel 'Phase - Tian'

* Middlebrook vs. Tian
plot db(tmb) db(ttian) ylabel 'Magnitude'
plot 180/pi*cphase(tmb) 180/pi*cphase(ttian) ylabel 'Phase'

write ota-improved_tb-loopgain.raw

*quit
.endc

**** end user architecture code
**.ends

* expanding   symbol:  ota1_simple.sym # of pins=7
** sym_path: /foss/designs/ChipAcharya/DSM/DSM_2ndOrder/1_Schematics/real_circuits/ota1_simple.sym
** sch_path: /foss/designs/ChipAcharya/DSM/DSM_2ndOrder/1_Schematics/real_circuits/ota1_simple.sch
.subckt ota1_simple AVDD PLUS MINUS VOUT IBIAS D_ENA AVSS
*.opin VOUT
*.ipin MINUS
*.ipin PLUS
*.ipin AVSS
*.ipin IBIAS
*.ipin AVDD
*.ipin D_ENA
XM01 net9 PLUS net1 AVSS sg13_lv_nmos w=161.5u l=2u ng=17 m=1
XM02 net10 MINUS net1 AVSS sg13_lv_nmos w=161.5u l=2u ng=17 m=1
XMt net1 net6 AVSS AVSS sg13_lv_nmos w=38u l=1u ng=4 m=1
XM08 VOUT net2 net5 AVSS sg13_lv_nmos w=95u l=1.5u ng=10 m=1
XM07 net3 net2 net4 AVSS sg13_lv_nmos w=95u l=1.5u ng=10 m=1
XM03 net4 net3 AVSS AVSS sg13_lv_nmos w=95u l=1.5u ng=10 m=1
XM04 net5 net3 AVSS AVSS sg13_lv_nmos w=95u l=1.5u ng=10 m=1
XMb1 net11 net6 AVSS AVSS sg13_lv_nmos w=38u l=1u ng=4 m=1
XM05 net3 net7 net9 AVDD sg13_lv_pmos w=385u l=1.5u ng=39 m=1
XM06 VOUT net7 net10 AVDD sg13_lv_pmos w=385u l=1.5u ng=39 m=1
XM09 net9 net8 AVDD AVDD sg13_lv_pmos w=500u l=1.5u ng=50 m=1
XM10 net10 net8 AVDD AVDD sg13_lv_pmos w=500u l=1.5u ng=50 m=1
XMb IBIAS net6 AVSS AVSS sg13_lv_nmos w=38u l=1u ng=4 m=1
XMb2 net11 net3 net8 AVDD sg13_lv_pmos w=385u l=1.5u ng=39 m=1
XMb3 net8 net8 AVDD AVDD sg13_lv_pmos w=385u l=1.5u ng=39 m=1
XMb5 net7 net8 AVDD AVDD sg13_lv_pmos w=385u l=1.5u ng=39 m=1
XMb4 AVSS net3 net7 AVDD sg13_lv_pmos w=50u l=0.5u ng=5 m=1
XMb10 AVDD VOUT net2 AVSS sg13_lv_nmos w=0.15u l=0.13u ng=1 m=1
XMb9 net2 net12 AVSS AVSS sg13_lv_nmos w=0.15u l=0.13u ng=1 m=1
XMb7 net8 VOUT net12 AVSS sg13_lv_nmos w=95u l=1.5u ng=10 m=1
XMb8 net12 net12 AVSS AVSS sg13_lv_nmos w=95u l=1.5u ng=10 m=1
XMb6 net8 net8 AVDD AVDD sg13_lv_pmos w=500u l=1.5u ng=50 m=1
XMe5 IBIAS net14 net6 AVSS sg13_lv_nmos w=1u l=0.13u ng=1 m=1
XMe2 net13 D_ENA AVSS AVSS sg13_lv_nmos w=1u l=0.13u ng=1 m=1
XMe4 net14 net13 AVSS AVSS sg13_lv_nmos w=1u l=0.13u ng=1 m=1
XMe6 net3 net13 AVSS AVSS sg13_lv_nmos w=1u l=0.13u ng=1 m=1
XMe3 net14 net13 AVDD AVDD sg13_lv_pmos w=1u l=0.13u ng=1 m=1
XMe1 net13 D_ENA AVDD AVDD sg13_lv_pmos w=1u l=0.13u ng=1 m=1
.ends

.GLOBAL GND
.end
