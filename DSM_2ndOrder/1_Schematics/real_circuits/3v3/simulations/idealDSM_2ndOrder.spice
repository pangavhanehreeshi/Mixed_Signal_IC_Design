** sch_path: /foss/designs/ChipAcharya/DSM/DSM_2ndOrder/1_Schematics/Ideal_Schematic/xschem/idealDSM_2ndOrder.sch
**.subckt idealDSM_2ndOrder
C1 net1 net2 1p m=1
S2 net3 net2 ph2 trip SW1
S3 net1 net4 ph2 trip SW1
S4 net2 VCM ph1 trip SW1
VDD VDD GND dc {vdd}
VCM1 VCM GND dc {vdd/2}
Vph2 ph2 GND PULSE(0V {vdd} 2.25us 100ns 100ns 2us 4.5us)
Vph1 ph1 GND PULSE(0V {vdd} 0ns 100ns 100ns 2us 4.5us)
C2 net3 VOUT 6p m=1
x1 q net9 ph1 vcmp resb 1.5 0 sg13g2_dfrbp_1
Vresb resb GND dc 0 pwl(0, 0, {per/2}, 0, {per/2+100p} {vdd})
x2 net4 vcmp 1.5 0 sg13g2_inv_1
S1 VIN net1 ph1 trip SW1
Etrip trip GND VDD GND {Etrip}
Vin VIN GND SINE({vdd/2} 0.7 80)
C3 net5 net6 1p m=1
S5 net7 net6 ph1 trip SW1
S6 net5 net4 ph1 trip SW1
S7 net6 VCM ph2 trip SW1
S8 VOUT net5 ph2 trip SW1
C4 net7 net8 3p m=1
x3 VOUT VCM net3 ideal_opamp
x4 net8 VCM net7 ideal_opamp
x5 VDD vcmp VCM ph2 net8 ideal_comparator
**** begin user architecture code

.control
save all

tran 100n 0.2ms 0 20n uic
plot v(VIN)
plot v(VOUT)
plot v(q)
plot v(vcmp)

.endc

.lib /foss/pdks/ihp-sg13g2/libs.tech/ngspice/models/cornerMOSlv.lib mos_tt
.lib /foss/pdks/ihp-sg13g2/libs.tech/ngspice/models/cornerRES.lib res_typ
.inc /foss/pdks/ihp-sg13g2/libs.ref/sg13g2_stdcell/spice/sg13g2_stdcell.spice

.param Etrip=0.5
.param per=1u
.param temp=27
.param vdd=1.5

**** end user architecture code
**.ends

* expanding   symbol:  /foss/designs/ChipAcharya/DSM/DSM_2ndOrder/1_Schematics/Ideal_Schematic/xschem/ideal_opamp.sym # of pins=3
** sym_path: /foss/designs/ChipAcharya/DSM/DSM_2ndOrder/1_Schematics/Ideal_Schematic/xschem/ideal_opamp.sym
** sch_path: /foss/designs/ChipAcharya/DSM/DSM_2ndOrder/1_Schematics/Ideal_Schematic/xschem/ideal_opamp.sch
.subckt ideal_opamp out inp inn
*.opin out
*.ipin inp
*.ipin inn
E1 out GND inp inn 1Meg
R1 out GND 100Meg m=1
.ends

* expanding   symbol:  /foss/designs/ChipAcharya/DSM/DSM_2ndOrder/1_Schematics/Ideal_Schematic/xschem/ideal_comparator.sym # of
*+ pins=5
** sym_path: /foss/designs/ChipAcharya/DSM/DSM_2ndOrder/1_Schematics/Ideal_Schematic/xschem/ideal_comparator.sym
** sch_path: /foss/designs/ChipAcharya/DSM/DSM_2ndOrder/1_Schematics/Ideal_Schematic/xschem/ideal_comparator.sch
.subckt ideal_comparator Vdd Vout Vinp clk Vinn
*.ipin Vinp
*.ipin Vinn
*.opin Vout
*.iopin Vdd
*.iopin clk
E1 diff GND Vinp Vinn 1
S1 diff sample tp clk SW1
E2 net1 GND sample GND 1
C1 sample GND 100p m=1
S2 net1 hold clk tp SW1
C2 hold GND 100p m=1
B1 Vout GND V={v(hold)>0?v(Vdd):0}
Etp tp GND Vdd GND 0.5
**** begin user architecture code

.ic v(hold)=1 v(sample)=1

**** end user architecture code
**** begin user architecture code

.param vdd=1.5

**** end user architecture code
.ends

.GLOBAL GND
.GLOBAL VDD
.GLOBAL VCM
.GLOBAL ph2
.GLOBAL ph1
**** begin user architecture code
.MODEL SW1 SW( VT=0.1 VH=0.0 RON=0.01 ROFF=10G )
.MODEL SW1 SW(VT=0.1 VH=0 RON=0.1 ROFF=100M)
**** end user architecture code
.end
