** sch_path: /foss/designs/ChipAcharya/DSM/DSM_2ndOrder/1_Schematics/real_circuits/1v2/tb_foldedcascode_nmos_loopgain.sch
**.subckt tb_foldedcascode_nmos_loopgain
Vdd v_dd GND 1.5
Vss v_ss GND 0
Vin v_in v_ss dc 0.75
C2 vr1 v_ss 2p m=1
I1 v_dd net1 40u
Vtest1 vf1 vr1 dc 0 ac 1
C1 net2 v_ss 2p m=1
I2 v_dd net3 40u
Vir1 net2 net5 0
.save i(vir1)
Vif1 net5 net4 0
.save i(vif1)
Itest1 v_ss net5 dc 0 ac 1
C3 net6 v_ss 2p m=1
I3 v_dd net7 40u
C4 net8 v_ss 2p m=1
I4 v_dd net9 40u
Itest3 v_ss vmeas1 dc 0 ac 0
Vtest2 vmeas1 net10 dc 0 ac 1
Vimeas1 net6 net10 0
.save i(vimeas1)
Itest2 v_ss vmeas2 dc 0 ac 1
Vtest3 vmeas2 net11 dc 0 ac 0
Vimeas2 net8 net11 0
.save i(vimeas2)
x3 v_dd net7 net6 vmeas1 v_in v_ena v_ss foldedcascode_nmos
x4 v_dd net9 net8 vmeas2 v_in v_ena v_ss foldedcascode_nmos
x1 v_dd net1 vr1 vf1 v_in v_ena v_ss foldedcascode_nmos
x2 v_dd net3 net2 net4 v_in v_ena v_ss foldedcascode_nmos
Venable v_ena v_ss 1.5
**** begin user architecture code

.lib cornerMOSlv.lib mos_tt
.lib cornerRES.lib res_typ

*.include /foss/designs/thesis/thesis_hp/designs/otas/3_kpex/foldedcascode_nmos_withdummies__foldedcascode_nmos_withdummies/magic_CC/foldedcascode_nmos_withdummies.pex.spice

.param temp=27
.options savecurrents reltol=1e-3 abstol=1e-12 gmin=1e-15
.control
save all

* Operating Point Analysis
op

* AC Analysis
ac dec 101 1 100G
remzerovec

* Middlebrook's Method
let tv  = -v(vr1)/v(vf1)
let ti  = -i(vir1)/i(vif1)
let tmb = (tv*ti - 1)/(tv + ti + 2)

* Tian's Method
* vtest=0, itest=1:
let A = i(Vimeas2)
let C = v(vmeas2)

* vtest=1, itest=0:
let B = i(Vimeas1)
let D = v(vmeas1)
let ttian = (A*D - B*C - A)/(2*(B*C - A*D) + A - D + 1)

optional interactive plots
plot db(tmb) ylabel 'Magnitude - Middlebrook'
plot 180/pi*cphase(tmb) ylabel 'Phase - Middlebrook'
plot db(ttian) ylabel 'Magnitude - Tian'
plot 180/pi*cphase(ttian) ylabel 'Phase - Tian'
plot db(tmb) db(ttian) ylabel 'Magnitude'
plot 180/pi*cphase(tmb) 180/pi*cphase(ttian) ylabel 'Phase'

* SINGLE clean write at the end
write foldedcascode_nmos_tb-loopgain.raw

.endc

**** end user architecture code
**.ends

* expanding   symbol:  foldedcascode_nmos.sym # of pins=7
** sym_path: /foss/designs/ChipAcharya/DSM/DSM_2ndOrder/1_Schematics/real_circuits/1v2/foldedcascode_nmos.sym
** sch_path: /foss/designs/ChipAcharya/DSM/DSM_2ndOrder/1_Schematics/real_circuits/1v2/foldedcascode_nmos.sch
.subckt foldedcascode_nmos AVDD IBIAS VOUT MINUS PLUS D_ENA AVSS
*.ipin AVSS
*.ipin IBIAS
*.ipin AVDD
*.ipin PLUS
*.ipin MINUS
*.opin VOUT
*.ipin D_ENA
XM23 IBIAS net3 AVSS AVSS sg13_lv_nmos w=8.5u l=5u ng=4 m=1
XM25 IBIAS net2 net3 AVSS sg13_lv_nmos w=1u l=0.13u ng=1 m=1
XM24 net10 net3 AVSS AVSS sg13_lv_nmos w=8.5u l=5u ng=4 m=1
XM19 net10 net5 net4 AVDD sg13_lv_pmos w=14u l=2u ng=4 m=1
XM20 net4 net4 AVDD AVDD sg13_lv_pmos w=14u l=2u ng=4 m=1
XM21 AVSS net5 net8 AVDD sg13_lv_pmos w=14u l=0.5u ng=4 m=1
XM22 net8 net4 AVDD AVDD sg13_lv_pmos w=14u l=2u ng=4 m=1
XM26 net7 net4 AVDD AVDD sg13_lv_pmos w=14u l=2u ng=4 m=1
XM27 net5 net8 net7 AVDD sg13_lv_pmos w=14u l=2u ng=4 m=1
XM28 net5 net15 net6 AVSS sg13_lv_nmos w=3u l=2u ng=2 m=1
XM29 net6 net5 AVSS AVSS sg13_lv_nmos w=3u l=2u ng=2 m=1
XM30 net9 net3 AVSS AVSS sg13_lv_nmos w=8.5u l=5u ng=4 m=1
XM31 net7 PLUS net9 AVSS sg13_lv_nmos w=6u l=1u ng=2 m=1
XM32 net11 MINUS net9 AVSS sg13_lv_nmos w=6u l=1u ng=2 m=1
XM42 AVDD net4 AVDD AVDD sg13_lv_pmos w=12u l=0.5u ng=4 m=1
XM41 AVDD net8 AVDD AVDD sg13_lv_pmos w=12u l=0.5u ng=4 m=1
XM38 AVSS net3 AVSS AVSS sg13_lv_nmos w=8u l=1u ng=4 m=1
XM33 net1 D_ENA AVDD AVDD sg13_lv_pmos w=1u l=0.13u ng=1 m=1
XM34 net2 net1 AVDD AVDD sg13_lv_pmos w=1u l=0.13u ng=1 m=1
XM35 net1 D_ENA AVSS AVSS sg13_lv_nmos w=1u l=0.13u ng=1 m=1
XM36 net2 net1 AVSS AVSS sg13_lv_nmos w=1u l=0.13u ng=1 m=1
XM37 net11 AVSS AVSS AVSS sg13_lv_nmos w=6u l=1u ng=2 m=1
XM39 VOUT net8 net11 AVDD sg13_lv_pmos w=14u l=2u ng=4 m=1
XM40 net11 net4 AVDD AVDD sg13_lv_pmos w=14u l=2u ng=4 m=1
XM43 VOUT net15 net12 AVSS sg13_lv_nmos w=3u l=2u ng=2 m=1
XM44 net12 net5 AVSS AVSS sg13_lv_nmos w=3u l=2u ng=2 m=1
XM45 net12 AVSS AVSS AVSS sg13_lv_nmos w=3u l=2u ng=2 m=1
XM46 VOUT AVSS AVSS AVSS sg13_lv_nmos w=3u l=2u ng=2 m=1
XM47 net11 AVDD AVDD AVDD sg13_lv_pmos w=14u l=2u ng=4 m=1
XM48 VOUT AVDD AVDD AVDD sg13_lv_pmos w=7u l=2u ng=2 m=1
XM49 net13 net4 AVDD AVDD sg13_lv_pmos w=14u l=2u ng=4 m=1
XM50 net13 VOUT net14 AVSS sg13_lv_nmos w=3u l=2u ng=2 m=1
XM51 net14 net14 AVSS AVSS sg13_lv_nmos w=3u l=2u ng=2 m=1
XM52 net15 net14 AVSS AVSS sg13_lv_nmos w=3u l=2u ng=2 m=1
XM53 AVDD VOUT net15 AVSS sg13_lv_nmos w=15u l=0.5u ng=4 m=1
XM54 AVSS net15 AVSS AVSS sg13_lv_nmos w=8u l=1u ng=4 m=1
XM55 net5 net1 AVSS AVSS sg13_lv_nmos w=1u l=0.13u ng=1 m=1
XM56 net7 AVSS AVSS AVSS sg13_lv_nmos w=6u l=1u ng=2 m=1
XM57 net5 AVDD AVDD AVDD sg13_lv_pmos w=7u l=2u ng=2 m=1
XM58 net6 AVSS AVSS AVSS sg13_lv_nmos w=3u l=2u ng=2 m=1
XM59 net5 AVSS AVSS AVSS sg13_lv_nmos w=3u l=2u ng=2 m=1
XM60 net4 AVDD AVDD AVDD sg13_lv_pmos w=7u l=2u ng=2 m=1
XM61 net14 AVSS AVSS AVSS sg13_lv_nmos w=3u l=2u ng=2 m=1
.ends

.GLOBAL GND
.end
